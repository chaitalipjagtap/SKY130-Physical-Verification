** sch_path: /home/lenovo/SKY130-Physical-Verification-Submission/My_Inverter/inverter.sch
**.subckt inverter
M1 VOUT VIN GND GND nmos w=1u l=0.18u m=1
M2 VOUT VIN net1 net1 pmos w=2u l=0.18u m=1
V1 net1 GND 1.8
V2 VIN GND PULSE(0
**.ends
.GLOBAL GND
.end
